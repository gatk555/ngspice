Test divide by 3 VHDL code

adut null [clk cout] d3
.model d3 d_cosim simulation=./wrapper.so

.tran 100n 10u
.control
*run
plot clk cout+1.5
.endc
.end
